# Ansys Electronics Desktop project, version 2025.2
materials:
  vacuum: permittivity=1
  copper: permeability=0.999991 conductivity=58000000

design Maxwell3DDesign1 (Maxwell 3D, Magnetostatic, model units mm)
geometry:
  Cylinder1 [copper] = cylinder(axis=Z, base_centre=(0mm, 0mm, 0mm), radius=5mm, height=20mm)
  Region [vacuum] = region(percentage_offset: +X=50, -X=50, +Y=50, -Y=50, +Z=0, -Z=0)
boundaries and excitations:
  Current1: Current Faces=Cylinder1.face(+z end) Current=1A IsSolid=true Point_out_of_terminal=false
  Current2: Current Faces=Cylinder1.face(-z end) Current=1A IsSolid=true Point_out_of_terminal=true
mesh:
  initial mesh: GlobalCurvilinear{Apply}
setups:
  Setup1: Magnetostatic MaximumPasses=10 MinimumPasses=2 MinimumConvergedPasses=1 PercentRefinement=30 PercentError=1 ConstantDelta=0s NonLinearResidual=0.001
